* NMOS Id–Vgs sweep (Sky130)

.lib "/home/oliviag/skywater130nm/volare/sky130/versions/a918dc7c8e474a99b68c85eb3546b4ed91fe9e7b/sky130A/libs.tech/ngspice/sky130.lib.spice" tt_77k

* Gate bias (fixed)
VGS GATE 0 1.2

* drain sweep source
VDS DRAIN 0 0

* MOSFET
XM1 DRAIN GATE 0 0 sky130_fd_pr__nfet_01v8_lvt w=1.6 l=0.15

* DC sweep
.dc VDS 0 1.85 0.01

.control
run
set filetype=ascii
wrdata mosfetVDS.txt v(DRAIN) i(VDS)
quit
.endc

.end
