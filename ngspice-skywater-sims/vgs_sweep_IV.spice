* NMOS Id–Vgs sweep (Sky130)

.lib "/home/oliviag/skywater130nm/volare/sky130/versions/a918dc7c8e474a99b68c85eb3546b4ed91fe9e7b/sky130A/libs.tech/ngspice/sky130.lib.spice" tt

* Drain bias
VDS DRAIN 0 1.85

* Gate sweep source
VGS GATE 0 0

* MOSFET
XM1 DRAIN GATE 0 0 sky130_fd_pr__nfet_01v8_lvt w=1.6 l=0.15

* DC sweep
.dc VGS 0 1.85 0.01

.control
run
set filetype=ascii
wrdata mosfetVGS.txt v(GATE) i(VDS)
quit
.endc

.end
