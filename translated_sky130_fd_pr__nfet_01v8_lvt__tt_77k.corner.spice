* --- Entirely Translated Master SPICE File ---

.include "/home/oliviag/skywater130nm/volare/sky130/versions/a918dc7c8e474a99b68c85eb3546b4ed91fe9e7b/sky130A/libs.tech/ngspice/parameters/lod.spice"

.subckt sky130_fd_pr__nfet_01v8_lvt d g s b
+ .param l=1 w=1 nf=1.0 ad=0 as=0 pd=0 ps=0 nrd=0 nrs=0 sa=0 sb=0 sd=0 mult=1

msky130_fd_pr__nfet_01v8_lvt d g s b sky130_fd_pr__nfet_01v8_lvt__model l={l} w={w} nf={nf} ad={ad} as={as} pd={pd} ps={ps} nrd={nrd} nrs={nrs} sa={sa} sb={sb} sd={sd} m={mult}

.model sky130_fd_pr__nfet_01v8_lvt__model nmos
+ level = 54
.param l = 1
.param l = l
*.param vth0_nom = 1.28751
*.param vsat_nom = 1.75772
*.param rdsw_nom = 0.967479
*.param u0_nom = 1.71788
*.param nfactor_nom = 32.1932
*.param eta0_nom = 1.40301
*.param delta_nom = 5.33214
.model sky130_fd_pr__nfet_01v8_lvt__model.0 nmos
.param lmin = 1.4e-07
.param lmax = 1.8e-07
.param wmin = 9e-07
.param wmax = 1.65e-06
+ toxm = 4.148e-09
+ xj = 1.5e-07
+ xl = 0
+ xw = 0
*+tnoimod=1
+ toxe = 4.148e-09+MC_MM_SWITCH*my_gauss*(4.148e-09*(sky130_fd_pr__nfet_01v8_lvt__toxe_slope1/sqrt(l*w*m)))
+ ndep = 1.7e+17
+ rsh = 1
+ vth0 = (3.199425423e-01+MC_MM_SWITCH*my_gauss*(sky130_fd_pr__nfet_01v8_lvt__vth0_slope1/sqrt(l*w*m)))*1.28751
+ k1 = 1.1629
+ k2 = -0.267505
+ k3 = 1.65
+ dvt1 = 0.1252
+ dvt2 = -0.05637
+ dvt0w = 0
+ dvt1w = 5.3e+06
+ dvt2w = -0.032
+ w0 = 1e-07
+ k3b = 1.6
+ vfb = 0
+ vsat = 7.842422391e+04*1.75772
+ ua = -9.55761e-11
+ ub = 1.34494e-18
+ uc = -6.7386e-11
+ rdsw = 103.65*0.967479
+ prwb = 0
+ prwg = 0
+ wr = 1
+ u0 = 4.308038042e-02*1.71788
+ a0 = 0
+ a1 = 0
+ a2 = 0.38689
+ ags = 0.442778
+ b0 = 0
+ b1 = 0
+ voff = -2.986804670e-01+MC_MM_SWITCH*my_gauss*(sky130_fd_pr__nfet_01v8_lvt__voff_slope/sqrt(l*w*m))
+ nfactor = (3.513481879e-01+MC_MM_SWITCH*my_gauss*(sky130_fd_pr__nfet_01v8_lvt__nfactor_slope/sqrt(l*w*m)))*32.1932
+ cit = -1.59917e-05
+ cdsc = 3.8556e-37
+ cdscb = -0.00011484
+ cdscd = 4.7984e-06
+ eta0 = -1.362264692e-01*1.40301
+ etab = -0.17544
+ pclm = 1.55436
+ pdiblcb = 0
+ alpha0 = 0.00014112
+ alpha1 = 0
+ beta0 = 23.3385
+ cgdo = 2.39289e-10
+ cgso = 2.39289e-10
+ cgbo = 1e-14
+ cf = 1e-14
+ ngate = 1e+23
* DC IV MOS Parameters
* BSIM4 - Model Selectors
* BSIM4 - Process Parameters
*(mismatch parameter sky130_fd_pr__nfet_01v8_lvt__toxe_slope_spectre)
* Threshold Voltage Parameters
*(mismatch parameter sky130_fd_pr__nfet_01v8_lvt__vth0_slope_spectre)
* NEW BSIM4 Parameters for Level 54
* Mobility Parameters
* BSIM4 - Mobility Parameters
* Subthreshold Current Parameters
*(mismatch parameter sky130_fd_pr__nfet_01v8_lvt__voff_slope_spectre)
*(mismatch parameter sky130_fd_pr__nfet_01v8_lvt__nfactor_slope_spectre)
* BSIM4 - Sub-threshold parameters
* Rout Parameters
* BSIM4 - Rout Parameters
* BSIM4 - Gate Induced Drain Leakage Model Parameters
* BSIM4 - Gate Leakage Current Parameters
* Temperature Effects Parameters
* BSIM4 - High Speed RF Model Parameters
* BSIM4 - Flicker and Thermal Noise Parameters
* BSIM4 - Layout Dependent Parasitic Model Parameters
* Diode DC IV Parameters
* BSIM4 - Diode DC IV parameters
* Diode and FET Capacitance Parameters
* BSIM4 - FET and Diode capacitance parameters
* Stress Parameters
.model sky130_fd_pr__nfet_01v8_lvt__model.1 nmos
.param lmin = 1.8e-07
.param lmax = 2.5e-07
.param wmin = 5.05e-06
.param wmax = 7e-06
+ toxm = 4.148e-09
+ xj = 1.5e-07
+ xl = 0
+ xw = 0
+ toxe = 4.148e-09+MC_MM_SWITCH*my_gauss*(4.148e-09*(sky130_fd_pr__nfet_01v8_lvt__toxe_slope1/sqrt(l*w*m)))
+ ndep = 1.7e+17
+ rsh = 1
+ vth0 = (6.118621589e-01+MC_MM_SWITCH*my_gauss*(sky130_fd_pr__nfet_01v8_lvt__vth0_slope1/sqrt(l*w*m)))*1.12168
+ k1 = 0.168285
+ k2 = 0.038855
+ k3 = 1.65
+ dvt1 = 0.1252
+ dvt2 = -0.05637
+ dvt0w = 0
+ dvt1w = 5.3e+06
+ dvt2w = -0.032
+ w0 = 1e-07
+ k3b = 1.6
+ vfb = 0
+ vsat = 1.900498318e+05*1.21519
+ ua = -3.17046e-09
+ ub = 4.75841e-18
+ uc = -1.27543e-11
+ rdsw = 103.65*1.38277
+ prwb = 0
+ prwg = 0
+ wr = 1
+ u0 = 2.105891285e-02*3.86037
+ a0 = 6.58798
+ a1 = 0
+ a2 = 0.38689
+ ags = -2.74985
+ b0 = 0
+ b1 = 0
+ voff = -1.745077203e-01+MC_MM_SWITCH*my_gauss*(sky130_fd_pr__nfet_01v8_lvt__voff_slope/sqrt(l*w*m))
+ nfactor = (2.563830907e-01+MC_MM_SWITCH*my_gauss*(sky130_fd_pr__nfet_01v8_lvt__nfactor_slope/sqrt(l*w*m)))*35
+ cit = -2.24104e-07
+ cdsc = 3.8556e-37
+ cdscb = -0.00011484
+ cdscd = 4.7984e-06
+ eta0 = -5.857628930e-02*4.17501
+ etab = 0.172025
+ pclm = 0.731048
+ pdiblcb = 0
+ alpha0 = 0.0209879
+ alpha1 = 0
+ beta0 = 50.6474
+ cgdo = 2.39289e-10
+ cgso = 2.39289e-10
+ cgbo = 1e-14
+ cf = 1e-14
+ ngate = 1e+23

.model sky130_fd_pr__nfet_01v8_lvt__model.2 nmos
.param lmin = 1.8e-07
.param lmax = 2.5e-07
.param wmin = 1e-06
.param wmax = 1.65e-06
+ toxm = 4.148e-09
+ xj = 1.5e-07
+ xl = 0
+ xw = 0
+ toxe = 4.148e-09+MC_MM_SWITCH*my_gauss*(4.148e-09*(sky130_fd_pr__nfet_01v8_lvt__toxe_slope1/sqrt(l*w*m)))
+ ndep = 1.7e+17
+ rsh = 1
+ vth0 = (6.221476949e-01+MC_MM_SWITCH*my_gauss*(sky130_fd_pr__nfet_01v8_lvt__vth0_slope1/sqrt(l*w*m)))*1.18565
+ k1 = 0.311334
+ k2 = 0.00236307
+ k3 = 1.65
+ dvt1 = 0.1252
+ dvt2 = -0.05637
+ dvt0w = 0
+ dvt1w = 5.3e+06
+ dvt2w = -0.032
+ w0 = 1e-07
+ k3b = 1.6
+ vfb = 0
+ vsat = 1.237662533e+05*1.22972
+ ua = -2.01358e-09
+ ub = 3.20134e-18
+ uc = 6.62716e-11
+ rdsw = 103.65*1.529
+ prwb = 0
+ prwg = 0
+ wr = 1
+ u0 = 2.577720036e-02*4.11137
+ a0 = 4.88924
+ a1 = 0
+ a2 = 0.38689
+ ags = -2.43839
+ b0 = 0
+ b1 = 0
+ voff = -1.642915643e-01+MC_MM_SWITCH*my_gauss*(sky130_fd_pr__nfet_01v8_lvt__voff_slope/sqrt(l*w*m))
+ nfactor = (1.168008132e+00+MC_MM_SWITCH*my_gauss*(sky130_fd_pr__nfet_01v8_lvt__nfactor_slope/sqrt(l*w*m)))*7.50508
+ cit = 2.11393e-05
+ cdsc = 3.8556e-37
+ cdscb = -0.00011484
+ cdscd = 4.7984e-06
+ eta0 = -1.564206905e-01*1.8545
+ etab = 0.0167426
+ pclm = 1.26125
+ pdiblcb = 0
+ alpha0 = 0.0035177
+ alpha1 = 0
+ beta0 = 33.4728
+ cgdo = 2.39289e-10
+ cgso = 2.39289e-10
+ cgbo = 1e-14
+ cf = 1e-14
+ ngate = 1e+23

.model sky130_fd_pr__nfet_01v8_lvt__model.3 nmos
.param lmin = 1e-06
.param lmax = 2e-06
.param wmin = 1e-06
.param wmax = 1.65e-06
+ toxm = 4.148e-09
+ xj = 1.5e-07
+ xl = 0
+ xw = 0
+ toxe = 4.148e-09+MC_MM_SWITCH*my_gauss*(4.148e-09*(sky130_fd_pr__nfet_01v8_lvt__toxe_slope/sqrt(l*w*m)))
+ ndep = 1.7e+17
+ rsh = 1
+ vth0 = (4.293740921e-01+MC_MM_SWITCH*my_gauss*(sky130_fd_pr__nfet_01v8_lvt__vth0_slope/sqrt(l*w*m)))*1.30949
+ k1 = 0.458369
+ k2 = -0.0232376
+ k3 = 1.65
+ dvt1 = 0.1252
+ dvt2 = -0.05637
+ dvt0w = 0
+ dvt1w = 5.3e+06
+ dvt2w = -0.032
+ w0 = 1e-07
+ k3b = 1.6
+ vfb = 0
+ vsat = 2.295621900e+03*16.6213
+ ua = -7.17982e-10
+ ub = 2.35394e-18
+ uc = 5.82303e-11
+ rdsw = 103.65*2.36
+ prwb = 0
+ prwg = 0
+ wr = 1
+ u0 = 3.615025215e-02*6.08023
+ a0 = 2.21564
+ a1 = 0
+ a2 = 0.38689
+ ags = 1.19312
+ b0 = 0
+ b1 = 0
+ voff = -1.188839056e-01+MC_MM_SWITCH*my_gauss*(sky130_fd_pr__nfet_01v8_lvt__voff_slope/sqrt(l*w*m))
+ nfactor = (7.336237045e-01+MC_MM_SWITCH*my_gauss*(sky130_fd_pr__nfet_01v8_lvt__nfactor_slope/sqrt(l*w*m)))*6.04219
+ cit = 1.48797e-05
+ cdsc = 3.8556e-37
+ cdscb = -0.00011484
+ cdscd = 4.7984e-06
+ eta0 = 5.649201940e-04*1
+ etab = -0.000527414
+ pclm = 0.256596
+ pdiblcb = 0
+ alpha0 = 0.00019995
+ alpha1 = 0
+ beta0 = 21.5995
+ cgdo = 2.39289e-10
+ cgso = 2.39289e-10
+ cgbo = 1e-14
+ cf = 1e-14
+ ngate = 1e+23

.model sky130_fd_pr__nfet_01v8_lvt__model.4 nmos
.param lmin = 5e-07
.param lmax = 1e-06
.param wmin = 1.65e-06
.param wmax = 3e-06
+ toxm = 4.148e-09
+ xj = 1.5e-07
+ xl = 0
+ xw = 0
+ toxe = 4.148e-09+MC_MM_SWITCH*my_gauss*(4.148e-09*(sky130_fd_pr__nfet_01v8_lvt__toxe_slope/sqrt(l*w*m)))
+ ndep = 1.7e+17
+ rsh = 1
+ vth0 = (4.427000038e-01+MC_MM_SWITCH*my_gauss*(sky130_fd_pr__nfet_01v8_lvt__vth0_slope/sqrt(l*w*m)))*1.29339
+ k1 = 0.445849
+ k2 = -0.0211123
+ k3 = 1.65
+ dvt1 = 0.1252
+ dvt2 = -0.05637
+ dvt0w = 0
+ dvt1w = 5.3e+06
+ dvt2w = -0.032
+ w0 = 1e-07
+ k3b = 1.6
+ vfb = 0
+ vsat = -1.930420324e+04*0.000175058
+ ua = -2.32225e-09
+ ub = 3.67243e-18
+ uc = 1.73923e-10
+ rdsw = 103.65*2.78088
+ prwb = 0
+ prwg = 0
+ wr = 1
+ u0 = 2.586542154e-02*11.342
+ a0 = 0.543606
+ a1 = 0
+ a2 = 0.38689
+ ags = 3.43632
+ b0 = 0
+ b1 = 0
+ voff = -1.361905003e-01+MC_MM_SWITCH*my_gauss*(sky130_fd_pr__nfet_01v8_lvt__voff_slope/sqrt(l*w*m))
+ nfactor = (8.855102774e-01+MC_MM_SWITCH*my_gauss*(sky130_fd_pr__nfet_01v8_lvt__nfactor_slope/sqrt(l*w*m)))*8.73855
+ cit = 5e-06
+ cdsc = 3.8556e-37
+ cdscb = -0.00011484
+ cdscd = 4.7984e-06
+ eta0 = 4.016844969e-03*1
+ etab = -0.000858944
+ pclm = -0.351261
+ pdiblcb = 0
+ alpha0 = 2.35264e-05
+ alpha1 = 0
+ beta0 = 18.7185
+ cgdo = 2.39289e-10
+ cgso = 2.39289e-10
+ cgbo = 1e-14
+ cf = 1e-14
+ ngate = 1e+23

.model sky130_fd_pr__nfet_01v8_lvt__model.5 nmos
.param lmin = 4e-06
.param lmax = 8e-06
.param wmin = 1e-06
.param wmax = 1.65e-06
+ toxm = 4.148e-09
+ xj = 1.5e-07
+ xl = 0
+ xw = 0
+ toxe = 4.148e-09+MC_MM_SWITCH*my_gauss*(4.148e-09*(sky130_fd_pr__nfet_01v8_lvt__toxe_slope/sqrt(l*w*m)))
+ ndep = 1.7e+17
+ rsh = 1
+ vth0 = (0.4229525+MC_MM_SWITCH*my_gauss*(sky130_fd_pr__nfet_01v8_lvt__vth0_slope/sqrt(l*w*m)))*1.32466
+ k1 = 0.53326
+ k2 = -0.0574106
+ k3 = 1.65
+ dvt1 = 0.1252
+ dvt2 = -0.05637
+ dvt0w = 0
+ dvt1w = 5.3e+06
+ dvt2w = -0.032
+ w0 = 1e-07
+ k3b = 1.6
+ vfb = 0
+ vsat = 200550.0*0.197719
+ ua = -9.79274e-10
+ ub = 2.30409e-18
+ uc = 2.23506e-11
+ rdsw = 103.65*0.00100201
+ prwb = 0
+ prwg = 0
+ wr = 1
+ u0 = 0.0312064*7.31298
+ a0 = 1.92082
+ a1 = 0
+ a2 = 0.38689
+ ags = 0.537176
+ b0 = 0
+ b1 = 0
+ voff = -0.11023409+MC_MM_SWITCH*my_gauss*(sky130_fd_pr__nfet_01v8_lvt__voff_slope/sqrt(l*w*m))
+ nfactor = (1.6893098+MC_MM_SWITCH*my_gauss*(sky130_fd_pr__nfet_01v8_lvt__nfactor_slope/sqrt(l*w*m)))*2.41414
+ cit = 1e-05
+ cdsc = 3.8556e-37
+ cdscb = -0.00011484
+ cdscd = 4.7984e-06
+ eta0 = 0.08*1
+ etab = -0.07
+ pclm = 0.2
+ pdiblcb = 0
+ alpha0 = 4.17349e-05
+ alpha1 = 0
+ beta0 = 17.7934
+ cgdo = 2.39289e-10
+ cgso = 2.39289e-10
+ cgbo = 1e-14
+ cf = 1e-14
+ ngate = 1e+23

.model sky130_fd_pr__nfet_01v8_lvt__model.6 nmos
.param lmin = 8e-06
.param lmax = 0.0001
.param wmin = 5.5e-07
.param wmax = 6.4e-07
+ toxm = 4.148e-09
+ xj = 1.5e-07
+ xl = 0
+ xw = 0
+ toxe = 4.148e-09+MC_MM_SWITCH*my_gauss*(4.148e-09*(sky130_fd_pr__nfet_01v8_lvt__toxe_slope/sqrt(l*w*m)))
+ ndep = 1.7e+17
+ rsh = 1
+ vth0 = (0.4229525+MC_MM_SWITCH*my_gauss*(sky130_fd_pr__nfet_01v8_lvt__vth0_slope/sqrt(l*w*m)))*1.06358
+ k1 = 0.53326
+ k2 = -0.0574106
+ k3 = 1.65
+ dvt1 = 0.1252
+ dvt2 = -0.05637
+ dvt0w = 0
+ dvt1w = 5.3e+06
+ dvt2w = -0.032
+ w0 = 1e-07
+ k3b = 1.6
+ vfb = 0
+ vsat = 200550.0*0.117696
+ ua = -9.79274e-10
+ ub = 2.30409e-18
+ uc = 2.23506e-11
+ rdsw = 103.65*35.9539
+ prwb = 0
+ prwg = 0
+ wr = 1
+ u0 = 0.0312064*9.30034
+ a0 = 1.92082
+ a1 = 0
+ a2 = 0.38689
+ ags = 0.537176
+ b0 = 0
+ b1 = 0
+ voff = -0.11023409+MC_MM_SWITCH*my_gauss*(sky130_fd_pr__nfet_01v8_lvt__voff_slope/sqrt(l*w*m))
+ nfactor = (1.6893098+MC_MM_SWITCH*my_gauss*(sky130_fd_pr__nfet_01v8_lvt__nfactor_slope/sqrt(l*w*m)))*23.4256
+ cit = 1e-05
+ cdsc = 3.8556e-37
+ cdscb = -0.00011484
+ cdscd = 4.7984e-06
+ eta0 = 0.08*1
+ etab = -0.07
+ pclm = 0.2
+ pdiblcb = 0
+ alpha0 = 4.17349e-05
+ alpha1 = 0
+ beta0 = 17.7934
+ cgdo = 2.39289e-10
+ cgso = 2.39289e-10
+ cgbo = 1e-14
+ cf = 1e-14
+ ngate = 1e+23
.model sky130_fd_pr__nfet_01v8_lvt__model.7 nmos
.param lmin = 8e-06
.param lmax = 0.0001
.param wmin = 7e-06
.param wmax = 0.0001
+ toxm = 4.148e-09
+ xj = 1.5e-07
+ xl = 0
+ xw = 0
+ toxe = 4.148e-09+MC_MM_SWITCH*my_gauss*(4.148e-09*(sky130_fd_pr__nfet_01v8_lvt__toxe_slope/sqrt(l*w*m)))
+ ndep = 1.7e+17
+ rsh = 1
+ vth0 = (0.417908+MC_MM_SWITCH*my_gauss*(sky130_fd_pr__nfet_01v8_lvt__vth0_slope/sqrt(l*w*m)))*1.25709
+ k1 = 0.47213
+ k2 = -0.033282
+ k3 = 1.65
+ dvt1 = 0.1252
+ dvt2 = -0.05637
+ dvt0w = 0
+ dvt1w = 5.3e+06
+ dvt2w = -0.032
+ w0 = 1e-07
+ k3b = 1.6
+ vfb = 0
+ vsat = 161140.0*0.0405727
+ ua = -1.30156e-09
+ ub = 2.67551e-18
+ uc = 7.0152e-11
+ rdsw = 103.65*144.793
+ prwb = 0
+ prwg = 0
+ wr = 1
+ u0 = 0.03198837*8.58843
+ a0 = 1.95984
+ a1 = 0
+ a2 = 0.38689
+ ags = 0.531793
+ b0 = 0
+ b1 = 0
+ voff = -0.11559919+MC_MM_SWITCH*my_gauss*(sky130_fd_pr__nfet_01v8_lvt__voff_slope/sqrt(l*w*m))
+ nfactor = (1.1019079+MC_MM_SWITCH*my_gauss*(sky130_fd_pr__nfet_01v8_lvt__nfactor_slope/sqrt(l*w*m)))*4.30869
+ cit = 1e-05
+ cdsc = 3.8556e-37
+ cdscb = -0.00011484
+ cdscd = 4.7984e-06
+ eta0 = 0.08*1
+ etab = -0.07
+ pclm = 0.2
+ pdiblcb = 0
+ alpha0 = 8.4345657e-5*1
+ alpha1 = 0
+ beta0 = 17.823
+ cgdo = 2.39289e-10
+ cgso = 2.39289e-10
+ cgbo = 1e-14
+ cf = 1e-14
+ ngate = 1e+23
*msky130_fd_pr__nfet_01v8_lvt d g s b sky130_fd_pr__nfet_01v8_lvt__model.0 l={l} w={w} nf={nf}
.ends sky130_fd_pr__nfet_01v8_lvt
